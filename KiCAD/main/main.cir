.title KiCad schematic
.include "/home/matias/VIPER/KiCAD/main/KiCad-Spice-Library/Models/Manufacturer/Infineon Technologies/infineon.lib"
.save all
.probe alli
.probe p(R14)
.probe p(R17)
.probe p(R15)
.probe p(R16)
.probe p(R13)
.probe p(C8)
.probe p(R18)
.probe p(C20)
.probe p(R6)
.probe p(R3)
.probe p(C9)
.probe p(C19)
.probe p(R12)
.probe p(R11)
.probe p(R2)
.probe p(R1)
.probe p(C4)
.probe p(C3)
.probe p(C2)
.probe p(C14)
.probe p(C11)
.probe p(C13)
.probe p(R5)
.probe p(L2)
.probe p(C10)
.probe p(R4)
.probe p(C6)
.probe p(C7)
.probe p(C12)
.probe p(L1)
.probe p(C17)
.probe p(C18)
.probe p(R7)
.probe p(C16)
.probe p(C1)
.probe p(C15)
.probe p(C5)
R14 +3.3V DAT0 10k
R17 +3.3V DAT3/CD 10k
R15 +3.3V CMD 10k
R16 +3.3V DAT2 10k
J4 __J4
R13 +3.3V DAT1 10k
C8 GND +3.3V 0.1u
D3 __D3
R18 Net-_D3-DIN_ NEOPXL_D 450
C20 SEL GND 0.1u
SW4 __SW4
SW2 __SW2
R6 ENC_PHS_A +3.3V 10k
R3 ENC_PHS_B +3.3V 10k
J2 __J2
C9 GND ENC_PHS_A 0.1u
C19 GND ENC_PHS_B 0.1u
R12 _STDBY +3.3V 10k
R11 _CHRG +3.3V 10k
U4 __U4
J1 __J1
R2 GND Net-_J1-CC2_ 5.1k
R1 Net-_J1-CC1_ GND 5.1k
C4 GND +3.3V 22u
C3 GND +3.3V 0.1u
J3 __J3
C2 GND +3.3V 1u
TDI1 __TDI1
TDO1 __TDO1
TCK1 __TCK1
TMS1 __TMS1
C14 GND +3.3V 10u
C11 GND Net-_U1-VREG_ 0.1u
U3 __U3
C13 Net-_U3-CTRL_ GND 100n
R5 DIO2 Net-_U3-CTRL_ 100
L2 Net-_U1-VR_PA_ Net-_FL1-RFO_ 18n
FL1 __FL1
U1 __U1
C10 +3.3V GND 0.1u
R4 +3.3V Net-_U1-_RESET_ 10k
C6 +3.3V GND 0.1u
C7 +3.3V GND 0.1u
C12 Net-_U1-VR_PA_ GND 22p
L1 Net-_U1-VREG_ Net-_U1-DCC_SW_ 15u
U7 __U7
C17 GND +3.3V 0.1u
C18 GND +3.3V 0.1u
U2 __U2
R7 Net-_U2-PROG_ GND 1.2k
C16 GND CHRG_BAT 10u
BT1 CHRG_BAT GND Battery_Cell
D2 __D2
C1 GND +5V 1u
C15 V+ GND 10u
SW1 __SW1
C5 Net-_U6-BP_ GND 470p
U6 U6.MIC5219
D1 __D1
.end
